* 5-band EQ, 60 Hz band at full boost (edit the pot values to change the setting)
* Generated by analysis/circuits.py
.include models.lib

Vcc vcc 0 12.0
Rv1 vcc vdiv 10k
Rv2 vdiv 0 10k
Cv vdiv 0 10u
Xref vdiv vref vcc 0 vref OPAMP

Vin in 0 DC 6 AC 1
Rx1 in eqa 2200.0
Xeq eqa eqb vcc 0 out OPAMP
Rx2 out eqb 2200.0
Req0a eqa w0 9999.0
Req0b w0 eqb 0.9999999999998899
Cs0 w0 g0 4.7e-06
Xg0 g0 vref vcc 0 GYRATOR params: RL=470.0 RG=68000.0 CG=4.7000000000000004e-08
Req1a eqa w1 5000.0
Req1b w1 eqb 5000.0
Cs1 w1 g1 1.5e-06
Xg1 g1 vref vcc 0 GYRATOR params: RL=470.0 RG=68000.0 CG=8.199999999999999e-09
Req2a eqa w2 5000.0
Req2b w2 eqb 5000.0
Cs2 w2 g2 3.8999999999999997e-07
Xg2 g2 vref vcc 0 GYRATOR params: RL=470.0 RG=68000.0 CG=2.2000000000000003e-09
Req3a eqa w3 5000.0
Req3b w3 eqb 5000.0
Cs3 w3 g3 1e-07
Xg3 g3 vref vcc 0 GYRATOR params: RL=470.0 RG=68000.0 CG=4.7e-10
Req4a eqa w4 5000.0
Req4b w4 eqb 5000.0
Cs4 w4 g4 2.7000000000000004e-08
Xg4 g4 vref vcc 0 GYRATOR params: RL=470.0 RG=68000.0 CG=1.2e-10

.control
ac dec 100 10 40k
plot vdb(out)
.endc
.end
