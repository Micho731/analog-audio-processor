* LM386 stage as built, 220 uF output capacitor
* Generated by analysis/circuits.py
.include models.lib

Vcc vcc 0 12.0
Rv1 vcc vdiv 10k
Rv2 vdiv 0 10k
Cv vdiv 0 10u
Xref vdiv vref vcc 0 vref OPAMP

Vin in 0 DC 6 AC 0.01
Ca in va 1u
Rvola 0 vw 9999.0
Rvolb vw va 0.9999999999998899
Xamp vw 0 vcc 0 ao LM386 params: GAIN=50
Rz ao zb 10
Cz zb 0 0.1u
Co ao spk 220u
Rspk spk 0 8

.control
ac dec 50 5 100k
plot vdb(spk)
.endc
.end
