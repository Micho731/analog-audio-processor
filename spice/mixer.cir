* Two inputs, 1 V AC on input 1
* Generated by analysis/circuits.py
.include models.lib

Vcc vcc 0 12.0
Rv1 vcc vdiv 10k
Rv2 vdiv 0 10k
Cv vdiv 0 10u
Xref vdiv vref vcc 0 vref OPAMP

Va a 0 AC 1
Vb b 0 0
Cm0 a p0 4.7u
Rm0a vref mw0 9999.0
Rm0b mw0 p0 0.9999999999998899
Rm0 mw0 sum 10000.0
Cm1 b p1 4.7u
Rm1a vref mw1 9999.0
Rm1b mw1 p1 0.9999999999998899
Rm1 mw1 sum 10000.0
Rmf out sum 10000.0
Xmix vref sum vcc 0 out OPAMP

.control
ac dec 50 10 100k
plot vdb(out)
.endc
.end
