* LED meter as built, 1 kHz tone of 2 V peak at the speaker
* Generated by analysis/circuits.py
.include models.lib

Vcc vcc 0 12.0
Rv1 vcc vdiv 10k
Rv2 vdiv 0 10k
Cv vdiv 0 10u
Xref vdiv vref vcc 0 vref OPAMP

Vin in 0 SIN(0 2 1k)
Rsensa 0 sw 9999.0
Rsensb sw in 0.9999999999998899
C1v sw d 10u
D5v 0 d D1N4148
D4v d n0 D1N4148
C2v n0 0 10u
D1v n0 n1 D1N4148
D2v n1 n2 D1N4148
D3v n2 n3 D1N4148
Rb0 n0 b0 10k
Q0 col0 b0 0 Q2N3904
Rc0 vcc a0_0 100.0
Dl0_0 a0_0 a0_1 LEDRED
Dl0_1 a0_1 a0_2 LEDRED
Dl0_2 a0_2 a0_3 LEDRED
Dl0_3 a0_3 a0_4 LEDRED
Dl0_4 a0_4 col0 LEDRED
Rb1 n1 b1 10k
Q1 col1 b1 0 Q2N3904
Rc1 vcc a1_0 100.0
Dl1_0 a1_0 a1_1 LEDRED
Dl1_1 a1_1 a1_2 LEDRED
Dl1_2 a1_2 a1_3 LEDRED
Dl1_3 a1_3 a1_4 LEDRED
Dl1_4 a1_4 col1 LEDRED
Rb2 n2 b2 10k
Q2 col2 b2 0 Q2N3904
Rc2 vcc a2_0 100.0
Dl2_0 a2_0 a2_1 LEDRED
Dl2_1 a2_1 a2_2 LEDRED
Dl2_2 a2_2 a2_3 LEDRED
Dl2_3 a2_3 a2_4 LEDRED
Dl2_4 a2_4 col2 LEDRED
Rb3 n3 b3 10k
Q3 col3 b3 0 Q2N3904
Rc3 vcc a3_0 100.0
Dl3_0 a3_0 a3_1 LEDRED
Dl3_1 a3_1 a3_2 LEDRED
Dl3_2 a3_2 a3_3 LEDRED
Dl3_3 a3_3 a3_4 LEDRED
Dl3_4 a3_4 col3 LEDRED

.control
tran 50u 400m 0 50u
plot (12-v(a0_0))/100 (12-v(a1_0))/100 (12-v(a2_0))/100 (12-v(a3_0))/100
.endc
.end
